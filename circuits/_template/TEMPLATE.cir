* TEMPLATE: REPLACE THIS LINE WITH CIRCUIT NAME IN ENGLISH, ANSI, MULTISIM 14.3
* FILE: <dir-name>.cir    ENCODING: ANSI (7-BIT ASCII)
* SIGNAL FLOW: VIN -> RIN -> Q1 -> RC -> VCC
* NOTE: comments must stay in English, non-ASCII breaks the Multisim importer
VIN IN 0 AC 10m SIN(0 10m 1k)
RIN IN MID 1k
Q1 OUT MID 0 2N2222
RC VCC OUT 4.7k
VCC VCC 0 12
.MODEL 2N2222 NPN(IS=1E-14 BF=200 VAF=100 IKF=0.3 BR=3 RB=10 RC=0.3 RE=0.2
+ TF=400E-12 TR=100E-9 CJE=25E-12 CJC=8E-12)
.OP
.AC DEC 10 10 1MEG
.TRAN 10u 5m 0 1u
.END
