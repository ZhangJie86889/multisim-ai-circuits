* 003-555-ASTABLE: NE555 ASTABLE MULTIVIBRATOR, ABOUT 1 KHZ SQUARE WAVE, ANSI
* FILE: 003-555-astable.cir    ENCODING: ANSI (7-BIT ASCII)
* SIGNAL FLOW: RA -> RB -> CT -> CC -> RPU -> XU1 -> RL -> VCC
* XU1 IS A BLACK BOX: PIN ORDER IS 1=GND 2=TRIG 3=OUT 4=RESET 5=CTRL 6=THR 7=DIS 8=VCC
* REPLACE IT WITH THE MULTISIM LIBRARY PART (MIXED / TIMER / LM555CN) AFTER IMPORT.
* THERE IS NO .MODEL LINE ON PURPOSE: NO .SUBCKT IS ALLOWED, SO THE INTERNAL
* CIRCUIT OF THE 555 CANNOT BE DESCRIBED HERE.
RA VCC DIS 8.2k
RB DIS THR 68k
CT THR 0 10n
CC CTRL 0 10n
RPU VCC RESET 10k
XU1 0 THR OUT RESET CTRL THR DIS VCC NE555
RL OUT 0 10k
VCC VCC 0 5
.TRAN 1u 10m 0 1u
.END
