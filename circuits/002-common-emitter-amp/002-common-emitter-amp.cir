* 002-COMMON-EMITTER-AMP: 2N2222 VOLTAGE-DIVIDER BIAS CE AMPLIFIER, ANSI, MULTISIM 14.3
* FILE: 002-common-emitter-amp.cir    ENCODING: ANSI (7-BIT ASCII)
* SIGNAL FLOW: VIN -> C1 -> R1 -> R2 -> Q1 -> RC -> RE1 -> RE2 -> CE -> C2 -> RL -> VCC
* RE2 IS BYPASSED BY CE SO THE AC GAIN IS SET BY RC / (RE1 + re)
VIN IN 0 AC 10m SIN(0 10m 1k)
C1 IN BASE 10u
R1 VCC BASE 47k
R2 BASE 0 8.2k
Q1 COL BASE EMIT 2N2222
RC VCC COL 4.7k
RE1 EMIT EMIT2 100
RE2 EMIT2 0 900
CE EMIT2 0 100u
C2 COL OUT 10u
RL OUT 0 10k
VCC VCC 0 12
.MODEL 2N2222 NPN(IS=1E-14 BF=200 VAF=100 IKF=0.3 BR=3 RB=10 RC=0.3 RE=0.2
+ TF=400E-12 TR=100E-9 CJE=25E-12 CJC=8E-12)
.OP
.AC DEC 10 10 1MEG
.TRAN 10u 5m 0 1u
.END
