* 001-BJT-SWITCH-LED: 2N2222 SATURATED SWITCH DRIVING A RED LED, ANSI, MULTISIM 14.3
* FILE: 001-bjt-switch-led.cir    ENCODING: ANSI (7-BIT ASCII)
* SIGNAL FLOW: VIN -> RB -> Q1 -> DLED -> RC -> VCC
* ELEMENT LINES ARE WRITTEN IN SIGNAL-FLOW ORDER SO MULTISIM PLACES
* COMPONENTS LEFT TO RIGHT ALONG THE SIGNAL PATH.
VIN IN 0 PULSE(0 5 0 1u 1u 0.5m 1m)
RB IN BASE 10k
Q1 COL BASE 0 2N2222
DLED COL DLEDN LED_RED
RC DLEDN VCC 1k
VCC VCC 0 5
.MODEL 2N2222 NPN(IS=1E-14 BF=200 VAF=100 IKF=0.3 BR=3 RB=10 RC=0.3 RE=0.2
+ TF=400E-12 TR=100E-9 CJE=25E-12 CJC=8E-12)
.MODEL LED_RED D(IS=1E-21 N=1.8 RS=2.5 BV=5 IBV=10u CJO=50p TT=5u)
.OP
.TRAN 1u 3m 0 1u
.END
