* 004-RC-LOWPASS: FIRST-ORDER RC LOW-PASS FILTER, FC ABOUT 1.59 KHZ, ANSI, MULTISIM 14.3
* FILE: 004-rc-lowpass.cir    ENCODING: ANSI (7-BIT ASCII)
* SIGNAL FLOW: VIN -> R1 -> C1
VIN IN 0 AC 1 SIN(0 1 1000)
R1 IN OUT 1k
C1 OUT 0 100n
.OP
.AC DEC 10 10 100k
.TRAN 1u 5m 0 1u
.END
